* RoadNode carrier: NTC charge gate. Battery temp swept -10..55..-10 C (V(temp) in volts = degC).
* Comparators: ideal open-drain (TLV7022 behaviour), output low when V(+) < V(-).
.param RTOP=100k R25=100k B=3950
V5   v5   0 5.17
VREF vref 0 3.3
Vtmp temp 0 PWL(0 -10 1 55 2 -10)
* NTC divider -> T node (also the ADC readback to GPIO5)
Rtop vref t {RTOP}
Bntc t 0 I=V(t)/1
Ct   t 0 100n
* A: cold comparator, + = ha, - = t, out = ok (wired with QB drain)
Ra1 vref ha 100k
Ra2 ha 0 300k
Rha ok ha 5.1Meg
Rpuo v5 ok 1Meg
Sa  ok 0 t ha swmod
* B: hot comparator, + = hb, - = t, out = hot (high = too hot)
Rb1 vref hb 470k
Rb2 hb 0 220k
Rhb hot hb 10Meg
Rpuh v5 hot 1Meg
Sb  hot 0 t hb swmod
* QB pulls ok low when hot; QG pulls P-FET gate low when ok
MQB ok hot 0 0 nmod
MQG pg ok 0 0 nmod
Rpg v5 pg 1Meg
* Load switch: on when V(v5)-V(pg) > 2 V
Bload chg 0 V=V(v5)*(V(v5)-V(pg) > 2 ? 1 : 0)
.model swmod sw vt=0 vh=0.001 ron=50 roff=1e12
.model nmod nmos level=1 vto=1.6 kp=0.05
.control
tran 1m 2
meas tran chg_max max v(chg)
.endc
.end
